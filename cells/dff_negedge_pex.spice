* NGSPICE file created from dff_negedge_layout.ext - technology: sky130A

.subckt dff_negedge_layout CLK VSS VDD D Q
X0 a_224_n362# clk vdd vdd sky130_fd_pr__pfet_01v8 ad=0.378 pd=3.12 as=0.378 ps=3.12 w=1.26 l=0.15
X1 q a_2732_n362# vdd vdd sky130_fd_pr__pfet_01v8 ad=0.378 pd=3.12 as=0.378 ps=3.12 w=1.26 l=0.15
X2 a_2096_n362# clk a_1524_n362# vdd sky130_fd_pr__pfet_01v8 ad=0.378 pd=3.12 as=0.378 ps=3.12 w=1.26 l=0.15
X3 a_784_n362# clk a_502_n362# vss sky130_fd_pr__nfet_01v8 ad=0.126 pd=1.44 as=0.126 ps=1.44 w=0.42 l=0.15
X4 a_2364_n362# clk a_2096_n362# vss sky130_fd_pr__nfet_01v8 ad=0.126 pd=1.44 as=0.126 ps=1.44 w=0.42 l=0.15
X5 a_1524_n362# a_784_n362# vss vss sky130_fd_pr__nfet_01v8 ad=0.126 pd=1.44 as=0.126 ps=1.44 w=0.42 l=0.15
X6 a_1168_n362# a_1524_n362# vdd vdd sky130_fd_pr__pfet_01v8 ad=0.378 pd=3.12 as=0.378 ps=3.12 w=1.26 l=0.15
X7 a_2364_n362# a_2732_n362# vss vss sky130_fd_pr__nfet_01v8 ad=0.126 pd=1.44 as=0.126 ps=1.44 w=0.42 l=0.15
X8 a_2732_n362# a_2096_n362# vdd vdd sky130_fd_pr__pfet_01v8 ad=0.378 pd=3.12 as=0.378 ps=3.12 w=1.26 l=0.15
X9 a_1168_n362# clk a_784_n362# vdd sky130_fd_pr__pfet_01v8 ad=0.378 pd=3.12 as=0.378 ps=3.12 w=1.26 l=0.15
X10 a_224_n362# clk vss vss sky130_fd_pr__nfet_01v8 ad=0.126 pd=1.44 as=0.126 ps=1.44 w=0.42 l=0.15
X11 a_502_n362# d vdd vdd sky130_fd_pr__pfet_01v8 ad=0.378 pd=3.12 as=0.378 ps=3.12 w=1.26 l=0.15
X12 q a_2732_n362# vss vss sky130_fd_pr__nfet_01v8 ad=0.126 pd=1.44 as=0.126 ps=1.44 w=0.42 l=0.15
X13 a_2096_n362# a_224_n362# a_1524_n362# vss sky130_fd_pr__nfet_01v8 ad=0.126 pd=1.44 as=0.126 ps=1.44 w=0.42 l=0.15
X14 a_1168_n362# a_1524_n362# vss vss sky130_fd_pr__nfet_01v8 ad=0.126 pd=1.44 as=0.126 ps=1.44 w=0.42 l=0.15
X15 a_2732_n362# a_2096_n362# vss vss sky130_fd_pr__nfet_01v8 ad=0.126 pd=1.44 as=0.126 ps=1.44 w=0.42 l=0.15
X16 a_1168_n362# a_224_n362# a_784_n362# vss sky130_fd_pr__nfet_01v8 ad=0.126 pd=1.44 as=0.126 ps=1.44 w=0.42 l=0.15
X17 a_784_n362# a_224_n362# a_502_n362# vdd sky130_fd_pr__pfet_01v8 ad=0.378 pd=3.12 as=0.378 ps=3.12 w=1.26 l=0.15
X18 a_502_n362# d vss vss sky130_fd_pr__nfet_01v8 ad=0.126 pd=1.44 as=0.126 ps=1.44 w=0.42 l=0.15
X19 a_2364_n362# a_224_n362# a_2096_n362# vdd sky130_fd_pr__pfet_01v8 ad=0.378 pd=3.12 as=0.378 ps=3.12 w=1.26 l=0.15
X20 a_1524_n362# a_784_n362# vdd vdd sky130_fd_pr__pfet_01v8 ad=0.378 pd=3.12 as=0.378 ps=3.12 w=1.26 l=0.15
X21 a_2364_n362# a_2732_n362# vdd vdd sky130_fd_pr__pfet_01v8 ad=0.378 pd=3.12 as=0.378 ps=3.12 w=1.26 l=0.15
C0 a_2364_n362# vdd 0.42286f
C1 clk a_784_n362# 0.23395f
C2 d a_1524_n362# 0
C3 a_2732_n362# clk 0.02009f
C4 clk a_224_n362# 0.71421f
C5 a_502_n362# clk 0.16104f
C6 d vdd 0.07498f
C7 a_2364_n362# clk 0.033f
C8 d clk 0.04624f
C9 a_1524_n362# vdd 0.42388f
C10 a_1168_n362# a_2096_n362# 0.01154f
C11 q a_2096_n362# 0
C12 a_1524_n362# clk 0.0699f
C13 clk vdd 1.09175f
C14 a_2096_n362# a_784_n362# 0
C15 a_2732_n362# a_2096_n362# 0.08286f
C16 a_2096_n362# a_224_n362# 0.18076f
C17 a_502_n362# a_2096_n362# 0
C18 a_1168_n362# a_784_n362# 0.21429f
C19 a_2364_n362# a_2096_n362# 0.21501f
C20 a_1168_n362# a_224_n362# 0.05366f
C21 a_2732_n362# q 0.07893f
C22 q a_224_n362# 0.00767f
C23 a_2364_n362# q 0.01992f
C24 a_1524_n362# a_2096_n362# 0.14536f
C25 a_2096_n362# vdd 0.35183f
C26 a_1168_n362# a_1524_n362# 0.18801f
C27 a_1168_n362# vdd 0.37869f
C28 a_2096_n362# clk 0.25584f
C29 a_784_n362# a_224_n362# 0.1493f
C30 q vdd 0.06831f
C31 a_502_n362# a_784_n362# 0.13535f
C32 a_2732_n362# a_224_n362# 0.03346f
C33 a_1168_n362# clk 0.10315f
C34 a_502_n362# a_224_n362# 0.05528f
C35 a_2732_n362# a_2364_n362# 0.16612f
C36 a_2364_n362# a_224_n362# 0.08708f
C37 q clk 0.00771f
C38 d a_784_n362# 0
C39 d a_224_n362# 0.03515f
C40 d a_502_n362# 0.04859f
C41 a_1524_n362# a_784_n362# 0.11033f
C42 a_784_n362# vdd 0.51485f
C43 a_1524_n362# a_224_n362# 0.16359f
C44 a_502_n362# a_1524_n362# 0
C45 a_2732_n362# vdd 0.38045f
C46 vdd a_224_n362# 0.44631f
C47 a_2364_n362# a_1524_n362# 0
C48 a_502_n362# vdd 0.11554f
C49 q vss 0.16455f
C50 d vss 0.17512f
C51 clk vss 1.67821f
C52 vdd vss 3.858f
C53 a_2364_n362# vss 0.33459f
C54 a_1168_n362# vss 0.30019f
C55 a_502_n362# vss 0.16246f
C56 a_2732_n362# vss 0.73859f
C57 a_2096_n362# vss 0.39655f
C58 a_1524_n362# vss 0.47214f
C59 a_784_n362# vss 0.51061f
C60 a_224_n362# vss 2.21018f
.ends
