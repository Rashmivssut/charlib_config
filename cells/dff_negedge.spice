* ==============================================================================
* Master-Slave D Flip-Flop (Negative-Edge Triggered)
* Complete Simulation Deck & Golden Netlist (Explicit Float Sizing)
* Technology: SkyWater 130nm (sky130.lib.spice tt)
* ==============================================================================

.lib /foss/pdks/sky130A/libs.tech/ngspice/sky130.lib.spice tt

* ------------------------------------------------------------------------------
* Solver Convergence Options
* ------------------------------------------------------------------------------
.options method=gear reltol=1e-3 trtol=1 gmin=1e-12

* ------------------------------------------------------------------------------
* Standard INVX1 Clean Load Cell (Fixed 1X)
* ------------------------------------------------------------------------------
.subckt invx1 in out vdd vss
xm01 out in vdd vdd sky130_fd_pr__pfet_01v8 l=0.15 w=1.26 as=0.378 ad=0.378 ps=3.12 pd=3.12
xm02 out in vss vss sky130_fd_pr__nfet_01v8 l=0.15 w=0.42 as=0.126 ad=0.126 ps=1.44 pd=1.44
.ends invx1

* ------------------------------------------------------------------------------
* D Flip-Flop Subcircuit Definition
* ------------------------------------------------------------------------------
.subckt dff_negedge D CLK VDD VSS Q

* --- Clock Inverter ---
xm_iclk_p clk_bar clk VDD VDD sky130_fd_pr__pfet_01v8 l=0.15 w=1.26 as=0.378 ad=0.378 ps=3.12 pd=3.12
xm_iclk_n clk_bar clk VSS VSS sky130_fd_pr__nfet_01v8 l=0.15 w=0.42 as=0.126 ad=0.126 ps=1.44 pd=1.44

* --- I1: Input Inverter ---
xm_i1_p   X1      D   VDD VDD sky130_fd_pr__pfet_01v8 l=0.15 w=1.26 as=0.378 ad=0.378 ps=3.12 pd=3.12
xm_i1_n   X1      D   VSS VSS sky130_fd_pr__nfet_01v8 l=0.15 w=0.42 as=0.126 ad=0.126 ps=1.44 pd=1.44

* --- TG1: Master Forward TG ---
xm_tg1_p  X2  clk_bar X1  VDD sky130_fd_pr__pfet_01v8 l=0.15 w=1.26 as=0.378 ad=0.378 ps=3.12 pd=3.12
xm_tg1_n  X1  clk     X2  VSS sky130_fd_pr__nfet_01v8 l=0.15 w=0.42 as=0.126 ad=0.126 ps=1.44 pd=1.44

* --- I2: Master Forward Inverter ---
xm_i2_p   X3      X2  VDD VDD sky130_fd_pr__pfet_01v8 l=0.15 w=1.26 as=0.378 ad=0.378 ps=3.12 pd=3.12
xm_i2_n   X3      X2  VSS VSS sky130_fd_pr__nfet_01v8 l=0.15 w=0.42 as=0.126 ad=0.126 ps=1.44 pd=1.44

* --- I3: Master Feedback Inverter ---
xm_i3_p   X4      X3  VDD VDD sky130_fd_pr__pfet_01v8 l=0.15 w=1.26 as=0.378 ad=0.378 ps=3.12 pd=3.12
xm_i3_n   X4      X3  VSS VSS sky130_fd_pr__nfet_01v8 l=0.15 w=0.42 as=0.126 ad=0.126 ps=1.44 pd=1.44

* --- TG2: Master Feedback TG ---
xm_tg2_p  X2  clk     X4  VDD sky130_fd_pr__pfet_01v8 l=0.15 w=1.26 as=0.378 ad=0.378 ps=3.12 pd=3.12
xm_tg2_n  X4  clk_bar X2  VSS sky130_fd_pr__nfet_01v8 l=0.15 w=0.42 as=0.126 ad=0.126 ps=1.44 pd=1.44

* --- TG3: Slave Forward TG ---
xm_tg3_p  X5  clk     X3  VDD sky130_fd_pr__pfet_01v8 l=0.15 w=1.26 as=0.378 ad=0.378 ps=3.12 pd=3.12
xm_tg3_n  X3  clk_bar X5  VSS sky130_fd_pr__nfet_01v8 l=0.15 w=0.42 as=0.126 ad=0.126 ps=1.44 pd=1.44

* --- I5: Slave Forward Inverter ---
xm_i5_p   X7      X5  VDD VDD sky130_fd_pr__pfet_01v8 l=0.15 w=1.26 as=0.378 ad=0.378 ps=3.12 pd=3.12
xm_i5_n   X7      X5  VSS VSS sky130_fd_pr__nfet_01v8 l=0.15 w=0.42 as=0.126 ad=0.126 ps=1.44 pd=1.44

* --- I6: Slave Feedback Inverter ---
xm_i6_p   X6      X7  VDD VDD sky130_fd_pr__pfet_01v8 l=0.15 w=1.26 as=0.378 ad=0.378 ps=3.12 pd=3.12
xm_i6_n   X6      X7  VSS VSS sky130_fd_pr__nfet_01v8 l=0.15 w=0.42 as=0.126 ad=0.126 ps=1.44 pd=1.44

* --- TG4: Slave Feedback TG ---
xm_tg4_p  X5  clk_bar X6  VDD sky130_fd_pr__pfet_01v8 l=0.15 w=1.26 as=0.378 ad=0.378 ps=3.12 pd=3.12
xm_tg4_n  X6  clk     X5  VSS sky130_fd_pr__nfet_01v8 l=0.15 w=0.42 as=0.126 ad=0.126 ps=1.44 pd=1.44

* --- I4: Output Driver Inverter ---
xm_i4_p   Q       X7  VDD VDD sky130_fd_pr__pfet_01v8 l=0.15 w=1.26 as=0.378 ad=0.378 ps=3.12 pd=3.12
xm_i4_n   Q       X7  VSS VSS sky130_fd_pr__nfet_01v8 l=0.15 w=0.42 as=0.126 ad=0.126 ps=1.44 pd=1.44

.ends dff_negedge

* ------------------------------------------------------------------------------
* Top-Level Testbench
* ------------------------------------------------------------------------------
Vdd vdd 0 DC 1.8
Vss vss 0 DC 0.0

* Clock: Period = 2.0 ns (500 MHz), Falling edges at 1.0ns, 3.0ns, 5.0ns, 7.0ns
Vclk clk 0 PULSE(0 1.8 0p 20p 20p 980p 2000p)

* Data Input: Setup ahead of 3.0ns (rising Q) and 5.0ns (falling Q)
Vd   d   0 PULSE(0 1.8 2200p 20p 20p 2000p 4000p)

* Device Under Test Instance
xdff d clk vdd 0 Q dff_negedge

* Standard 1X Inverter Load Instance
xload Q q_load_out vdd 0 invx1

* ------------------------------------------------------------------------------
* Extended Transient Simulation (10 ns) & Timing Extraction
* ------------------------------------------------------------------------------
.tran 1p 10000p

.control
run

* Rise Time on Q (20% to 80%)
meas tran t_rise TRIG v(Q) VAL=0.36 RISE=1 TARG v(Q) VAL=1.44 RISE=1 FROM=3.0n TO=4.0n

* Fall Time on Q (80% to 20%)
meas tran t_fall TRIG v(Q) VAL=1.44 FALL=1 TARG v(Q) VAL=0.36 FALL=1 FROM=5.0n TO=6.0n

* Clock-to-Q Delays (Each window contains exactly 1 falling edge: FALL=1)
meas tran tp_cq_lh TRIG v(clk) VAL=0.9 FALL=1 TARG v(Q) VAL=0.9 RISE=1 FROM=3.0n TO=4.0n
meas tran tp_cq_hl TRIG v(clk) VAL=0.9 FALL=1 TARG v(Q) VAL=0.9 FALL=1 FROM=5.0n TO=6.0n

let tp_cq = (tp_cq_hl + tp_cq_lh) / 2
print t_rise t_fall tp_cq_lh tp_cq_hl tp_cq

* Plot CLK and Q cleanly
plot v(Q) v(clk)+2
.endc

.end
