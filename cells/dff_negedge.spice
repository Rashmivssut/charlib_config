* ------------------------------------------------------------------------------
* D Flip-Flop Subcircuit Definition
* ------------------------------------------------------------------------------
.subckt dff_negedge D CLK VDD VSS Q

* --- Clock Inverter ---
xm_iclk_p clk_bar clk VDD VDD sky130_fd_pr__pfet_01v8 l=0.15 w=1.26 as=0.378 ad=0.378 ps=3.12 pd=3.12
xm_iclk_n clk_bar clk VSS VSS sky130_fd_pr__nfet_01v8 l=0.15 w=0.42 as=0.126 ad=0.126 ps=1.44 pd=1.44

* --- I1: Input Inverter ---
xm_i1_p   X1      D   VDD VDD sky130_fd_pr__pfet_01v8 l=0.15 w=1.26 as=0.378 ad=0.378 ps=3.12 pd=3.12
xm_i1_n   X1      D   VSS VSS sky130_fd_pr__nfet_01v8 l=0.15 w=0.42 as=0.126 ad=0.126 ps=1.44 pd=1.44

* --- TG1: Master Forward TG ---
xm_tg1_p  X2  clk_bar X1  VDD sky130_fd_pr__pfet_01v8 l=0.15 w=1.26 as=0.378 ad=0.378 ps=3.12 pd=3.12
xm_tg1_n  X1  clk     X2  VSS sky130_fd_pr__nfet_01v8 l=0.15 w=0.42 as=0.126 ad=0.126 ps=1.44 pd=1.44

* --- I2: Master Forward Inverter ---
xm_i2_p   X3      X2  VDD VDD sky130_fd_pr__pfet_01v8 l=0.15 w=1.26 as=0.378 ad=0.378 ps=3.12 pd=3.12
xm_i2_n   X3      X2  VSS VSS sky130_fd_pr__nfet_01v8 l=0.15 w=0.42 as=0.126 ad=0.126 ps=1.44 pd=1.44

* --- I3: Master Feedback Inverter ---
xm_i3_p   X4      X3  VDD VDD sky130_fd_pr__pfet_01v8 l=0.15 w=1.26 as=0.378 ad=0.378 ps=3.12 pd=3.12
xm_i3_n   X4      X3  VSS VSS sky130_fd_pr__nfet_01v8 l=0.15 w=0.42 as=0.126 ad=0.126 ps=1.44 pd=1.44

* --- TG2: Master Feedback TG ---
xm_tg2_p  X2  clk     X4  VDD sky130_fd_pr__pfet_01v8 l=0.15 w=1.26 as=0.378 ad=0.378 ps=3.12 pd=3.12
xm_tg2_n  X4  clk_bar X2  VSS sky130_fd_pr__nfet_01v8 l=0.15 w=0.42 as=0.126 ad=0.126 ps=1.44 pd=1.44

* --- TG3: Slave Forward TG ---
xm_tg3_p  X5  clk     X3  VDD sky130_fd_pr__pfet_01v8 l=0.15 w=1.26 as=0.378 ad=0.378 ps=3.12 pd=3.12
xm_tg3_n  X3  clk_bar X5  VSS sky130_fd_pr__nfet_01v8 l=0.15 w=0.42 as=0.126 ad=0.126 ps=1.44 pd=1.44

* --- I5: Slave Forward Inverter ---
xm_i5_p   X7      X5  VDD VDD sky130_fd_pr__pfet_01v8 l=0.15 w=1.26 as=0.378 ad=0.378 ps=3.12 pd=3.12
xm_i5_n   X7      X5  VSS VSS sky130_fd_pr__nfet_01v8 l=0.15 w=0.42 as=0.126 ad=0.126 ps=1.44 pd=1.44

* --- I6: Slave Feedback Inverter ---
xm_i6_p   X6      X7  VDD VDD sky130_fd_pr__pfet_01v8 l=0.15 w=1.26 as=0.378 ad=0.378 ps=3.12 pd=3.12
xm_i6_n   X6      X7  VSS VSS sky130_fd_pr__nfet_01v8 l=0.15 w=0.42 as=0.126 ad=0.126 ps=1.44 pd=1.44

* --- TG4: Slave Feedback TG ---
xm_tg4_p  X5  clk_bar X6  VDD sky130_fd_pr__pfet_01v8 l=0.15 w=1.26 as=0.378 ad=0.378 ps=3.12 pd=3.12
xm_tg4_n  X6  clk     X5  VSS sky130_fd_pr__nfet_01v8 l=0.15 w=0.42 as=0.126 ad=0.126 ps=1.44 pd=1.44

* --- I4: Output Driver Inverter ---
xm_i4_p   Q       X7  VDD VDD sky130_fd_pr__pfet_01v8 l=0.15 w=1.26 as=0.378 ad=0.378 ps=3.12 pd=3.12
xm_i4_n   Q       X7  VSS VSS sky130_fd_pr__nfet_01v8 l=0.15 w=0.42 as=0.126 ad=0.126 ps=1.44 pd=1.44

.ends dff_negedge
