* NGSPICE file created from dff_negedge_layout.ext - technology: sky130A

.subckt dff_negedge_layout clk vss vdd d q
X0 a_224_n362# clk vdd vdd sky130_fd_pr__pfet_01v8 ad=0.378 pd=3.12 as=0.378 ps=3.12 w=1.26 l=0.15
**devattr s=15120,624 d=15120,624
X1 q a_2732_n362# vdd vdd sky130_fd_pr__pfet_01v8 ad=0.378 pd=3.12 as=0.378 ps=3.12 w=1.26 l=0.15
**devattr s=15120,624 d=15120,624
X2 a_2096_n362# clk a_1524_n362# vdd sky130_fd_pr__pfet_01v8 ad=0.378 pd=3.12 as=0.378 ps=3.12 w=1.26 l=0.15
**devattr s=15120,624 d=15120,624
X3 a_784_n362# clk a_502_n362# vss sky130_fd_pr__nfet_01v8 ad=0.126 pd=1.44 as=0.126 ps=1.44 w=0.42 l=0.15
**devattr s=5040,288 d=5040,288
X4 a_2364_n362# clk a_2096_n362# vss sky130_fd_pr__nfet_01v8 ad=0.126 pd=1.44 as=0.126 ps=1.44 w=0.42 l=0.15
**devattr s=5040,288 d=5040,288
X5 a_1524_n362# a_784_n362# vss vss sky130_fd_pr__nfet_01v8 ad=0.126 pd=1.44 as=0.126 ps=1.44 w=0.42 l=0.15
**devattr s=5040,288 d=5040,288
X6 a_1168_n362# a_1524_n362# vdd vdd sky130_fd_pr__pfet_01v8 ad=0.378 pd=3.12 as=0.378 ps=3.12 w=1.26 l=0.15
**devattr s=15120,624 d=15120,624
X7 a_2364_n362# a_2732_n362# vss vss sky130_fd_pr__nfet_01v8 ad=0.126 pd=1.44 as=0.126 ps=1.44 w=0.42 l=0.15
**devattr s=5040,288 d=5040,288
X8 a_2732_n362# a_2096_n362# vdd vdd sky130_fd_pr__pfet_01v8 ad=0.378 pd=3.12 as=0.378 ps=3.12 w=1.26 l=0.15
**devattr s=15120,624 d=15120,624
X9 a_1168_n362# clk a_784_n362# vdd sky130_fd_pr__pfet_01v8 ad=0.378 pd=3.12 as=0.378 ps=3.12 w=1.26 l=0.15
**devattr s=15120,624 d=15120,624
X10 a_224_n362# clk vss vss sky130_fd_pr__nfet_01v8 ad=0.126 pd=1.44 as=0.126 ps=1.44 w=0.42 l=0.15
**devattr s=5040,288 d=5040,288
X11 a_502_n362# d vdd vdd sky130_fd_pr__pfet_01v8 ad=0.378 pd=3.12 as=0.378 ps=3.12 w=1.26 l=0.15
**devattr s=15120,624 d=15120,624
X12 q a_2732_n362# vss vss sky130_fd_pr__nfet_01v8 ad=0.126 pd=1.44 as=0.126 ps=1.44 w=0.42 l=0.15
**devattr s=5040,288 d=5040,288
X13 a_2096_n362# a_224_n362# a_1524_n362# vss sky130_fd_pr__nfet_01v8 ad=0.126 pd=1.44 as=0.126 ps=1.44 w=0.42 l=0.15
**devattr s=5040,288 d=5040,288
X14 a_1168_n362# a_1524_n362# vss vss sky130_fd_pr__nfet_01v8 ad=0.126 pd=1.44 as=0.126 ps=1.44 w=0.42 l=0.15
**devattr s=5040,288 d=5040,288
X15 a_2732_n362# a_2096_n362# vss vss sky130_fd_pr__nfet_01v8 ad=0.126 pd=1.44 as=0.126 ps=1.44 w=0.42 l=0.15
**devattr s=5040,288 d=5040,288
X16 a_1168_n362# a_224_n362# a_784_n362# vss sky130_fd_pr__nfet_01v8 ad=0.126 pd=1.44 as=0.126 ps=1.44 w=0.42 l=0.15
**devattr s=5040,288 d=5040,288
X17 a_784_n362# a_224_n362# a_502_n362# vdd sky130_fd_pr__pfet_01v8 ad=0.378 pd=3.12 as=0.378 ps=3.12 w=1.26 l=0.15
**devattr s=15120,624 d=15120,624
X18 a_502_n362# d vss vss sky130_fd_pr__nfet_01v8 ad=0.126 pd=1.44 as=0.126 ps=1.44 w=0.42 l=0.15
**devattr s=5040,288 d=5040,288
X19 a_2364_n362# a_224_n362# a_2096_n362# vdd sky130_fd_pr__pfet_01v8 ad=0.378 pd=3.12 as=0.378 ps=3.12 w=1.26 l=0.15
**devattr s=15120,624 d=15120,624
X20 a_1524_n362# a_784_n362# vdd vdd sky130_fd_pr__pfet_01v8 ad=0.378 pd=3.12 as=0.378 ps=3.12 w=1.26 l=0.15
**devattr s=15120,624 d=15120,624
X21 a_2364_n362# a_2732_n362# vdd vdd sky130_fd_pr__pfet_01v8 ad=0.378 pd=3.12 as=0.378 ps=3.12 w=1.26 l=0.15
**devattr s=15120,624 d=15120,624
.ends
